// VerilogA for SAR_VerilogA, VerilogA_D_FlipFlop, veriloga
`include "constants.vams"
`include "disciplines.vams"

module VerilogA_DFlipFlop(SB,RB,clk,Q,Qb,vdd,vss);

parameter real vtrans=0.5;
parameter real delay = 0;
parameter real ttime = 1p;
parameter real clk_threshold = 0.5;

inout vdd,vss;
input SB,RB;
output Q,Qb;

electrical SB,RB,Q,Qb,vdd,vss;
real d_0,d_0b;

analog begin

 @(cross(V(clk) - clk_threshold, +1))
 begin
    if(V(RB) == 0) begin
    d_0 = 0; d_0b = 1; end
 else if(V(SB) == 0) begin
    d_0 = 1; d_0b = 0; end
 end

 V(Q) <+ transition(d_0,delay,ttime);
 V(Qb) <+ transition(d_0b,delay,ttime);
end

endmodule
