// VerilogA for SAR_VerilogA, VerilogA_D_FlipFlop, veriloga

`include "constants.vams"
`include "disciplines.vams"

module VerilogA_SRlipFlop(RB,SB,Q,Qb,vdd,vss);

parameter real vtrans=0.5;
parameter real delay = 0;
parameter real ttime = 1p;
parameter real clk_threshold = 0.9;

inout vdd,vss;
input RB,SB;
output Q,Qb;

electrical RB,SB,Q,Qb,vdd,vss;
real d_0,d_0b;

analog begin

   // if((V(RB) < clk_threshold) && (V(SB) > clk_threshold)) begin
      // d_0 = V(vdd); d_0b = V(vss); end
   // else if((V(RB) > clk_threshold) && (V(SB) < clk_threshold)) begin
      // d_0 = V(vss); d_0b = V(vdd); end
   // else if((V(RB) < clk_threshold) && (V(SB) < clk_threshold)) begin
      // d_0 = d_0; d_0b = d_0b; end

   // $strobe("clk = %d RB = %d SB = %d",V(clk),V(RB),V(SB)) ;
   if((V(RB) < clk_threshold) && (V(SB) < clk_threshold)) begin
      d_0 = d_0; d_0b = d_0b; end
   else if(V(RB) > clk_threshold) begin
      d_0 = V(vss); d_0b = V(vdd); end
   else if(V(SB) > clk_threshold) begin
      d_0 = V(vdd); d_0b = V(vss); end

   V(Q) <+ transition(d_0,delay,ttime);
   V(Qb) <+ transition(d_0b,delay,ttime);

end

endmodule
